* Simple DC Resistive Circuit(first.sp)

V1 1 0 DC 10
R1 1 0 1k

.op

.end
